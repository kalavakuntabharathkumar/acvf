// demo Spectre netlist: xor2_x1
simulator lang=spectre
