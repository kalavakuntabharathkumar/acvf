// demo Spectre netlist: nand2_x1
simulator lang=spectre
