// demo Spectre netlist: buf_x4
simulator lang=spectre
