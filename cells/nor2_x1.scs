// demo Spectre netlist: nor2_x1
simulator lang=spectre
