// demo Spectre netlist: and2_x1
simulator lang=spectre
