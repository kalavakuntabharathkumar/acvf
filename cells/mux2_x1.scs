// demo Spectre netlist: mux2_x1
simulator lang=spectre
