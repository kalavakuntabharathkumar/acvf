// demo Spectre netlist: inv_x1
simulator lang=spectre
