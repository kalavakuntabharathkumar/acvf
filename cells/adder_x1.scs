// demo Spectre netlist: adder_x1
simulator lang=spectre
